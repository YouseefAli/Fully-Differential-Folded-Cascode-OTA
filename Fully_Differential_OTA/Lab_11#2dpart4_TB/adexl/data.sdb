ADE simulation setup
Run mode: Single Run, Sweeps and Corners
Tests:
  Fully_Differential_OTA:Lab_11-part4_TB:1: Fully_Differential_OTA/Lab_11-part4_TB/schematic, simulator spectre
Global variables:
  CL = 0.5p
  IB = 10u
  VCASCN = 1.08
  VCASCP = 1.276
  VDD = 2.5
  VICM = 0.55
  VICMAC = 0
  VID = 0
  VIDAC = 1
  VREF = 2.077
