ADE simulation setup
Run mode: Single Run, Sweeps and Corners
Tests:
  iti_labs:Lab_11:1: iti_labs/Lab_11/schematic, simulator spectre
    Variables: VDS = 0.45; VGS = 0.9; L = 0.1u:0.1u:2u; W = 10u
