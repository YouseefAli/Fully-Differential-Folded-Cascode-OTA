ADE simulation setup
Test iti_labs:Lab_11:1: iti_labs/Lab_11/schematic, simulator spectre
  Models: /home/cadence/Desktop/ee214b.sp, /home/cadence/Desktop/save.scs
  Variables: W = 10u; VDS = 0.45; VGS = 0.9
  Temperature: 27
  Operating points saved: /M1 (vdsat gmoverid id gds cgg gm); /M0 (gmoverid is cgg gds gm)
  Analysis dc: sweep VGS start=0 stop=1.8 step=10m (saves the operating point)
  Output (OS("/M1" "gm") / OS("/M1" "cgg")) (unticked)
  Output (OS("/M1" "gm") / OS("/M1" "gds")) (unticked)
  Output OS("/M1" "gmoverid") (unticked)
  Output OS("/M1" "vdsat") (unticked)
  Output Nmos_gm/cgg = waveVsWave(?x OS("/M1" "gmoverid") ?y (OS("/M1" "gm") / OS("/M1" "cgg")))
  Output Nmos_gm*ro = waveVsWave(?x OS("/M1" "gmoverid") ?y (OS("/M1" "gm") / OS("/M1" "gds")))
  Output Nmos_ID/W = waveVsWave(?x OS("/M1" "gmoverid") ?y (OS("/M1" "id") / VAR("W")))
  Output Nmos_VGS = waveVsWave(?x OS("/M1" "gmoverid") ?y VS("/net7"))
  Output (OS("/M0" "gm") / OS("/M0" "gds")) (unticked)
  Output (OS("/M0" "gm") / OS("/M0" "cgg")) (unticked)
  Output (OS("/M0" "is") / VAR("W")) (unticked)
  Output Pmos_gm*ro = waveVsWave(?x OS("/M0" "gmoverid") ?y (OS("/M0" "gm") / OS("/M0" "gds")))
  Output Pmos_ID/W = waveVsWave(?x OS("/M0" "gmoverid") ?y (OS("/M0" "is") / VAR("W")))
  Output Pmos_VGS = waveVsWave(?x OS("/M0" "gmoverid") ?y VS("/net7"))
  Output OS("/M0" "gmoverid") (unticked)
  Output Pmos_gm/cgg = waveVsWave(?x OS("/M0" "gmoverid") ?y (OS("/M0" "gm") / OS("/M0" "cgg")))
  Output (OS("/M1" "id") / VAR("W")) (unticked)
Run mode: Single Run, Sweeps and Corners
Setup values for test iti_labs:Lab_11:1: L = 0.1u:0.1u:2u
