ADE simulation setup
Run mode: Single Run, Sweeps and Corners
Tests:
  Fully_Differential_OTA:Lab_11-part3:1: Fully_Differential_OTA/Lab_11-part3/schematic, simulator spectre
Global variables:
  CL = 500f
  IB = 10u
  VCASCN = 1.08
  VCASCP = 1.276
  VDD = 2.5
  VICM = 0.55
  VICMAC = 0
  VID = 0
  VIDAC = 1
  VREF = 1.25
  W = 8u
  W1 = 1.45u
